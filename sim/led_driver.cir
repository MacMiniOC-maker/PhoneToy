* PhoneToy button-light driver: GPIO -> 1k -> 2N2222 -> 5 V arcade LED
* Open in LTspice or KiCad's simulator as-is, or run:  ngspice -b led_driver.cir
.param RLED=330   ; resistor inside the button's LED (unknown until measured; swept by run.py)
.param RB=1k      ; base resistor
.param VGPIO=3.3  ; GPIO high level

V5    vcc  0  5
VG    gpio_i 0 {VGPIO}
RG    gpio_i gpio 30          ; ESP32-S3 pin output resistance, roughly
RBASE gpio base {RB}
Q1    coll base 0 Q2N2222
DLED  vcc  led  LEDBLUE
RL    led  coll {RLED}

.model Q2N2222 NPN(IS=14.34f XTI=3 EG=1.11 VAF=74.03 BF=255.9 NE=1.307 ISE=14.34f IKF=.2847
+ XTB=1.5 BR=6.092 NC=2 ISC=0 IKR=0 RC=1 CJC=7.306p MJC=.3416 VJC=.75 FC=.5 CJE=22.01p
+ MJE=.377 VJE=.75 TR=46.91n TF=411.1p ITF=.6 VTF=1.7 XTF=3 RB=10)
* Blue/white LED, about 3.0 V at 20 mA
.model LEDBLUE D(IS=1.4e-22 N=2.5 RS=5)

.op
.control
run
print i(V5) i(VG) v(coll) v(base)
.endc
.end
