* Button light dimmed with 1 kHz PWM (what the firmware's LEDC timer does)
.param RLED=330
V5    vcc  0  5
VG    gpio_i 0 PULSE(0 3.3 0 5n 5n 0.5m 1m)
RG    gpio_i gpio 30
RBASE gpio base 1k
Q1    coll base 0 Q2N2222
DLED  vcc  led  LEDBLUE
RL    led  coll {RLED}
.model Q2N2222 NPN(IS=14.34f XTI=3 EG=1.11 VAF=74.03 BF=255.9 NE=1.307 ISE=14.34f IKF=.2847
+ XTB=1.5 BR=6.092 NC=2 ISC=0 IKR=0 RC=1 CJC=7.306p MJC=.3416 VJC=.75 FC=.5 CJE=22.01p
+ MJE=.377 VJE=.75 TR=46.91n TF=411.1p ITF=.6 VTF=1.7 XTF=3 RB=10)
.model LEDBLUE D(IS=1.4e-22 N=2.5 RS=5)
.tran 0.2u 2m
.control
run
meas tran t_on  TRIG v(gpio_i) VAL=1.65 RISE=2 TARG v(coll) VAL=2.5 FALL=2
meas tran t_off TRIG v(gpio_i) VAL=1.65 FALL=2 TARG v(coll) VAL=2.5 RISE=2
.endc
.end
