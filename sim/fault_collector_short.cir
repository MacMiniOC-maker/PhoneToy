* Fault: the button light (or its wire) shorts, so the transistor's collector
* sits directly on the 5 V rail while the GPIO turns the transistor on.
.param RB=1k
V5    vcc  0  5
RSH   vcc  coll 0.05
VG    gpio_i 0 3.3
RG    gpio_i gpio 30
RBASE gpio base {RB}
Q1    coll base 0 Q2N2222
.model Q2N2222 NPN(IS=14.34f XTI=3 EG=1.11 VAF=74.03 BF=255.9 NE=1.307 ISE=14.34f IKF=.2847
+ XTB=1.5 BR=6.092 NC=2 ISC=0 IKR=0 RC=1 CJC=7.306p MJC=.3416 VJC=.75 FC=.5 CJE=22.01p
+ MJE=.377 VJE=.75 TR=46.91n TF=411.1p ITF=.6 VTF=1.7 XTF=3 RB=10)
.op
.control
run
print i(V5) i(VG) v(coll)
.endc
.end
